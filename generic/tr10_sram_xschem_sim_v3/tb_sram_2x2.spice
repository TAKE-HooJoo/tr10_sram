* Standalone ngspice testbench corresponding to tb_sram_2x2.sch
.include models_generic.spice
.include sram_core.spice

VVDD VDD 0 5
VA0 A0 0 PWL(0 0 34.9n 0 35n 5 64.9n 5 65n 0 80n 0)
VCE CE 0 PWL(0 0 4.9n 0 5n 5 14.9n 5 15n 0 19.9n 0 20n 5 29.9n 5 30n 0 34.9n 0 35n 5 44.9n 5 45n 0 49.9n 0 50n 5 59.9n 5 60n 0 64.9n 0 65n 5 74.9n 5 75n 0 80n 0)
VWE WE 0 PWL(0 0 4.9n 0 5n 5 14.9n 5 15n 0 34.9n 0 35n 5 44.9n 5 45n 0 80n 0)
VDIN0 DIN0 0 PWL(0 5 14.9n 5 15n 0 80n 0)
VDIN1 DIN1 0 PWL(0 0 34.9n 0 35n 5 44.9n 5 45n 0 80n 0)

XSRAM A0 CE WE DIN0 DIN1 DOUT0 DOUT1 VDD 0 SRAM2X2
.tran 0.02n 80n
.save all
.end
