* 2 word x 2 bit single-port SRAM - generic functional SPICE reference deck
* VDD=5 V, L=1 um. Replace generic models with TR-10 PDK before MPW use.
.include models_generic.spice

.subckt INV A Y VDD VSS
MP1 Y A VDD VDD pmos W=6u L=1u
MN1 Y A VSS VSS nmos W=3u L=1u
.ends INV

.subckt NAND2 A B Y VDD VSS
MPA Y A VDD VDD pmos W=6u L=1u
MPB Y B VDD VDD pmos W=6u L=1u
MNA Y A NINT VSS nmos W=6u L=1u
MNB NINT B VSS VSS nmos W=6u L=1u
.ends NAND2

.subckt ROWDEC A0 CE WL0 WL1 VDD VSS
XIA A0 A0B VDD VSS INV
XN0 CE A0B N0 VDD VSS NAND2
XI0 N0 WL0 VDD VSS INV
XN1 CE A0 N1 VDD VSS NAND2
XI1 N1 WL1 VDD VSS INV
.ends ROWDEC

.subckt SRAM6T BL BLB WL VDD VSS
MP1 Q QB VDD VDD pmos W=3u L=1u
MN1 Q QB VSS VSS nmos W=6u L=1u
MP2 QB Q VDD VDD pmos W=3u L=1u
MN2 QB Q VSS VSS nmos W=6u L=1u
MAX1 BL WL Q VSS nmos W=4u L=1u
MAX2 BLB WL QB VSS nmos W=4u L=1u
.ends SRAM6T

.subckt WRDRV DIN CE WE BL BLB VDD VSS
XID DIN DINB VDD VSS INV
XNW CE WE NW VDD VSS NAND2
XIW NW WREN VDD VSS INV
MBL1 BL DINB NBL VSS nmos W=10u L=1u
MBL2 NBL WREN VSS VSS nmos W=10u L=1u
MBLB1 BLB DIN NBLB VSS nmos W=10u L=1u
MBLB2 NBLB WREN VSS VSS nmos W=10u L=1u
.ends WRDRV

.subckt READPC BL BLB CE DOUT VDD VSS
PP0 BL CE VDD VDD pmos W=12u L=1u
PP1 BLB CE VDD VDD pmos W=12u L=1u
XREAD BLB DOUT VDD VSS INV
.ends READPC

.subckt SRAM2X2 A0 CE WE DIN0 DIN1 DOUT0 DOUT1 VDD VSS
XDEC A0 CE WL0 WL1 VDD VSS ROWDEC
XB00 BL0 BL0B WL0 VDD VSS SRAM6T
XB10 BL0 BL0B WL1 VDD VSS SRAM6T
XB01 BL1 BL1B WL0 VDD VSS SRAM6T
XB11 BL1 BL1B WL1 VDD VSS SRAM6T
XWR0 DIN0 CE WE BL0 BL0B VDD VSS WRDRV
XWR1 DIN1 CE WE BL1 BL1B VDD VSS WRDRV
XRD0 BL0 BL0B CE DOUT0 VDD VSS READPC
XRD1 BL1 BL1B CE DOUT1 VDD VSS READPC
.ends SRAM2X2

VVDD VDD 0 5
VA0 A0 0 PWL(0 0 34.9n 0 35n 5 64.9n 5 65n 0 80n 0)
VCE CE 0 PWL(0 0 4.9n 0 5n 5 14.9n 5 15n 0 19.9n 0 20n 5 29.9n 5 30n 0 34.9n 0 35n 5 44.9n 5 45n 0 49.9n 0 50n 5 59.9n 5 60n 0 64.9n 0 65n 5 74.9n 5 75n 0 80n 0)
VWE WE 0 PWL(0 0 4.9n 0 5n 5 14.9n 5 15n 0 34.9n 0 35n 5 44.9n 5 45n 0 80n 0)
VDIN0 DIN0 0 PWL(0 0 34.9n 0 35n 5 44.9n 5 45n 0 80n 0)
VDIN1 DIN1 0 PWL(0 5 14.9n 5 15n 0 80n 0)
XMEM A0 CE WE DIN0 DIN1 DOUT0 DOUT1 VDD 0 SRAM2X2

.tran 0.02n 80n
.meas tran R0_B0 FIND V(DOUT0) AT=25n
.meas tran R0_B1 FIND V(DOUT1) AT=25n
.meas tran R1_B0 FIND V(DOUT0) AT=55n
.meas tran R1_B1 FIND V(DOUT1) AT=55n
.meas tran R0B_B0 FIND V(DOUT0) AT=70n
.meas tran R0B_B1 FIND V(DOUT1) AT=70n
.end
