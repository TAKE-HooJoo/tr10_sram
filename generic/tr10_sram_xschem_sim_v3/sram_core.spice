* 2 word x 2 bit single-port SRAM
* Pins: A0 CE WE DIN0 DIN1 DOUT0 DOUT1 VDD VSS

.subckt INV A Y VDD VSS
MP0 Y A VDD VDD PMOS W=6u L=1u
MN0 Y A VSS VSS NMOS W=3u L=1u
.ends INV

.subckt NAND2 A B Y VDD VSS
MP0 Y A VDD VDD PMOS W=6u L=1u
MP1 Y B VDD VDD PMOS W=6u L=1u
MN0 Y A NINT VSS NMOS W=6u L=1u
MN1 NINT B VSS VSS NMOS W=6u L=1u
.ends NAND2

.subckt AND2 A B Y VDD VSS
XN0 A B NBAR VDD VSS NAND2
XI0 NBAR Y VDD VSS INV
.ends AND2

* Conventional 6T bit cell.
* Cell ratio: pull-down NMOS > access NMOS > pull-up PMOS.
.subckt SRAM6T BL BLB WL VDD VSS
MPQ  Q  QB VDD VDD PMOS W=4u  L=1u
MNQ  Q  QB VSS VSS NMOS W=12u L=1u
MPQB QB Q  VDD VDD PMOS W=4u  L=1u
MNQB QB Q  VSS VSS NMOS W=12u L=1u
MAX0 BL  WL Q  VSS NMOS W=8u L=1u
MAX1 BLB WL QB VSS NMOS W=8u L=1u
.ends SRAM6T

.subckt ROWDEC A0 CE WL0 WL1 VDD VSS
XIA   A0 A0B VDD VSS INV
XAND0 CE A0B WL0 VDD VSS AND2
XAND1 CE A0  WL1 VDD VSS AND2
.ends ROWDEC

* Write driver: bitlines are precharged high; during CE=WE=1
* the selected complementary bitline is pulled low.
.subckt WRDRV DIN CE WE BL BLB VDD VSS
XID   DIN DINB VDD VSS INV
XEN   CE WE WEN VDD VSS AND2
XG0   WEN DINB GBL  VDD VSS AND2
XG1   WEN DIN  GBLB VDD VSS AND2
MPL0  BL  GBL  VSS VSS NMOS W=18u L=1u
MPL1  BLB GBLB VSS VSS NMOS W=18u L=1u
.ends WRDRV

* Precharge when CE=0. Read is a simple static inverter sensing BLB.
* This is intentionally simple for first functional bring-up.
.subckt READPC CE BL BLB DOUT VDD VSS
MPRE0 BL  CE VDD VDD PMOS W=12u L=1u
MPRE1 BLB CE VDD VDD PMOS W=12u L=1u
MEQ   BL  CE BLB VDD PMOS W=6u L=1u
XOUT  BLB DOUT VDD VSS INV
.ends READPC

.subckt SRAM2X2 A0 CE WE DIN0 DIN1 DOUT0 DOUT1 VDD VSS
XDEC A0 CE WL0 WL1 VDD VSS ROWDEC

* column 0 = data bit 0
XC00 BL0 BL0B WL0 VDD VSS SRAM6T
XC10 BL0 BL0B WL1 VDD VSS SRAM6T
XW0  DIN0 CE WE BL0 BL0B VDD VSS WRDRV
XR0  CE BL0 BL0B DOUT0 VDD VSS READPC

* column 1 = data bit 1
XC01 BL1 BL1B WL0 VDD VSS SRAM6T
XC11 BL1 BL1B WL1 VDD VSS SRAM6T
XW1  DIN1 CE WE BL1 BL1B VDD VSS WRDRV
XR1  CE BL1 BL1B DOUT1 VDD VSS READPC
.ends SRAM2X2
