** sch_path: /home/take/Design/tr10_sram/sram/sram_16w16b_top.sch
.subckt sram_16w16b_top VDD WLE DOUT0 VSS A0 WE DIN0 PCB DOUT15 DIN15
*.PININFO VDD:B WLE:I DOUT0:O VSS:B A0:I WE:I DIN0:I PCB:I DOUT15:O DIN15:I
x4 VDD VSS PCB EQEN BL0 BLB0 BL15 BLB15 precharge
x5 VDD VSS BLB0 BLB15 DOUT0 DOUT15 read_buffer
MXM1 WEB WE VSS VSS NMOS w=3.4u l=1u
MXM2 WEB WE VDD VDD PMOS w=6.8u l=1u
MXM3 EQEN PCB VSS VSS NMOS w=3.4u l=1u
MXM4 EQEN PCB VDD VDD PMOS w=6.8u l=1u
x12 DIN0 VDD BL0 BLB0 VSS VSS BL1 WE BLB1 WEB write_driver
x13 VSS VDD BL2 BLB2 VSS VSS BL3 WE BLB3 WEB write_driver
x14 VSS VDD BL4 BLB4 VSS VSS BL5 WE BLB5 WEB write_driver
x15 VSS VDD BL6 BLB6 VSS VSS BL7 WE BLB7 WEB write_driver
x16 VSS VDD BL8 BLB8 VSS VSS BL9 WE BLB9 WEB write_driver
x17 VSS VDD BL10 BLB10 VSS VSS BL11 WE BLB11 WEB write_driver
x18 VSS VDD BL12 BLB12 VSS VSS BL13 WE BLB13 WEB write_driver
x19 VSS VDD BL14 BLB14 VSS DIN15 BL15 WE BLB15 WEB write_driver
x1 VDD VSS BLB10 BL9 BLB8 BL13 BL12 BLB12 BLB9 BL11 BL10 BL14 BLB14 BLB13 BLB15 BL15 BLB11 BL8 BL5 BLB4 BL1 BL4 BLB3 BLB0 BL3 BLB7
+ BLB2 BL7 BLB6 BL6 BLB5 BL2 BLB1 BL0 VSS VSS VSS VSS VSS WL15 VSS VSS VSS VSS VSS WL0 VSS VSS VSS VSS sram_16w16b
x3 VDD VSS WL0 WLE A0 net1 decoder
x6 VDD VSS net2 WLE A0 net3 decoder
x7 VDD VSS net4 WLE A0 net5 decoder
x8 VDD VSS net6 WLE A0 net7 decoder
x9 VDD VSS net8 WLE A0 net9 decoder
x10 VDD VSS net10 WLE A0 net11 decoder
x11 VDD VSS net12 WLE A0 net13 decoder
x20 VDD VSS net14 WLE A0 WL15 decoder
.ends

* expanding   symbol:  precharge.sym # of pins=8
** sym_path: /home/take/Design/tr10_sram/sram/precharge.sym
** sch_path: /home/take/Design/tr10_sram/sram/precharge.sch
.subckt precharge VDD VSS PCB EQEN BL0 BLB0 BL1 BLB1
*.PININFO VDD:B VSS:B PCB:I EQEN:I BL0:B BLB0:B BL1:B BLB1:B
MXM9 BL0 PCB VDD VDD PMOS w=3.4u l=1u
MXM10 BLB0 PCB VDD VDD PMOS w=3.4u l=1u
MXM11 BL0 EQEN BLB0 VSS NMOS w=3.4u l=1u
MXM12 BL1 PCB VDD VDD PMOS w=3.4u l=1u
MXM13 BLB1 PCB VDD VDD PMOS w=3.4u l=1u
MXM14 BL1 EQEN BLB1 VSS NMOS w=3.4u l=1u
.ends

* expanding   symbol:  read_buffer.sym # of pins=6
** sym_path: /home/take/Design/tr10_sram/sram/read_buffer.sym
** sch_path: /home/take/Design/tr10_sram/sram/read_buffer.sch
.subckt read_buffer VDD VSS BLB0 BLB1 DOUT0 DOUT1
*.PININFO VDD:B VSS:B BLB0:I BLB1:I DOUT0:O DOUT1:O
MXM15 DOUT0 BLB0 VDD VDD PMOS w=6.8u l=1u
MXM16 DOUT0 BLB0 VSS VSS NMOS w=3.4u l=1u
MXM1 DOUT1 BLB1 VDD VDD PMOS w=6.8u l=1u
MXM2 DOUT1 BLB1 VSS VSS NMOS w=3.4u l=1u
.ends

* expanding   symbol:  write_driver.sym # of pins=10
** sym_path: /home/take/Design/tr10_sram/sram/write_driver.sym
** sch_path: /home/take/Design/tr10_sram/sram/write_driver.sch
.subckt write_driver DIN0 VDD BL0 BLB0 VSS DIN1 BL1 WE BLB1 WEB
*.PININFO DIN0:I DIN1:I WE:I WEB:I BL0:B BLB0:B BL1:B BLB1:B VDD:B VSS:B
MXM15 DIN0B DIN0 VDD VDD PMOS w=6.8u l=1u
MXM16 DIN0B DIN0 VSS VSS NMOS w=3.4u l=1u
MXM7 BL0 WE DIN0 VSS NMOS w=5.2u l=1u
MXM8 DIN0 WEB BL0 VDD PMOS w=6.8u l=1u
MXM1 BLB0 WE DIN0B VSS NMOS w=5.2u l=1u
MXM2 DIN0B WEB BLB0 VDD PMOS w=6.8u l=1u
MXM3 DIN1B DIN1 VDD VDD PMOS w=6.8u l=1u
MXM4 DIN1B DIN1 VSS VSS NMOS w=3.4u l=1u
MXM5 BL1 WE DIN1 VSS NMOS w=5.2u l=1u
MXM6 DIN1 WEB BL1 VDD PMOS w=6.8u l=1u
MXM9 BLB1 WE DIN1B VSS NMOS w=5.2u l=1u
MXM10 DIN1B WEB BLB1 VDD PMOS w=6.8u l=1u
.ends

* expanding   symbol:  sram_16w16b.sym # of pins=50
** sym_path: /home/take/Design/tr10_sram/sram/sram_16w16b.sym
** sch_path: /home/take/Design/tr10_sram/sram/sram_16w16b.sch
.subckt sram_16w16b VDD VSS BLB10 BL9 BLB8 BL13 BL12 BLB12 BLB9 BL11 BL10 BL14 BLB14 BLB13 BLB15 BL15 BLB11 BL8 BL5 BLB4 BL1 BL4
+ BLB3 BLB0 BL3 BLB7 BLB2 BL7 BLB6 BL6 BLB5 BL2 BLB1 BL0 WL14 WL12 WL10 WL8 WL13 WL15 WL11 WL9 WL6 WL4 WL2 WL0 WL5 WL7 WL3 WL1
*.PININFO WL0:I WL1:I WL2:I WL3:I WL4:I WL5:I WL6:I WL7:I WL8:I WL9:I WL10:I WL11:I WL12:I WL13:I WL14:I WL15:I VDD:B VSS:B
*+ BLB10:B BL9:B BLB8:B BL13:B BL12:B BLB12:B BLB9:B BL11:B BL10:B BL14:B BLB14:B BLB13:B BLB15:B BL15:B BLB11:B BL8:B BL5:B BLB4:B BL1:B
*+ BL4:B BLB3:B BLB0:B BL3:B BLB7:B BLB2:B BL7:B BLB6:B BL6:B BLB5:B BL2:B BLB1:B BL0:B
x1 WL0 VDD VSS WL1 BLB10 BL9 BLB8 BL13 BL12 BLB12 BLB9 BL11 BL10 BL14 BLB14 BLB13 BLB15 BL15 BLB11 BL8 BL5 BLB4 BL1 BL4 BLB3 BLB0
+ BL3 BLB7 BLB2 BL7 BLB6 BL6 BLB5 BL2 BLB1 BL0 sram_2w16b
x2 WL2 VDD VSS WL3 BLB10 BL9 BLB8 BL13 BL12 BLB12 BLB9 BL11 BL10 BL14 BLB14 BLB13 BLB15 BL15 BLB11 BL8 BL5 BLB4 BL1 BL4 BLB3 BLB0
+ BL3 BLB7 BLB2 BL7 BLB6 BL6 BLB5 BL2 BLB1 BL0 sram_2w16b
x3 WL4 VDD VSS WL5 BLB10 BL9 BLB8 BL13 BL12 BLB12 BLB9 BL11 BL10 BL14 BLB14 BLB13 BLB15 BL15 BLB11 BL8 BL5 BLB4 BL1 BL4 BLB3 BLB0
+ BL3 BLB7 BLB2 BL7 BLB6 BL6 BLB5 BL2 BLB1 BL0 sram_2w16b
x4 WL6 VDD VSS WL7 BLB10 BL9 BLB8 BL13 BL12 BLB12 BLB9 BL11 BL10 BL14 BLB14 BLB13 BLB15 BL15 BLB11 BL8 BL5 BLB4 BL1 BL4 BLB3 BLB0
+ BL3 BLB7 BLB2 BL7 BLB6 BL6 BLB5 BL2 BLB1 BL0 sram_2w16b
x5 WL8 VDD VSS WL9 BLB10 BL9 BLB8 BL13 BL12 BLB12 BLB9 BL11 BL10 BL14 BLB14 BLB13 BLB15 BL15 BLB11 BL8 BL5 BLB4 BL1 BL4 BLB3 BLB0
+ BL3 BLB7 BLB2 BL7 BLB6 BL6 BLB5 BL2 BLB1 BL0 sram_2w16b
x6 WL10 VDD VSS WL11 BLB10 BL9 BLB8 BL13 BL12 BLB12 BLB9 BL11 BL10 BL14 BLB14 BLB13 BLB15 BL15 BLB11 BL8 BL5 BLB4 BL1 BL4 BLB3
+ BLB0 BL3 BLB7 BLB2 BL7 BLB6 BL6 BLB5 BL2 BLB1 BL0 sram_2w16b
x7 WL12 VDD VSS WL13 BLB10 BL9 BLB8 BL13 BL12 BLB12 BLB9 BL11 BL10 BL14 BLB14 BLB13 BLB15 BL15 BLB11 BL8 BL5 BLB4 BL1 BL4 BLB3
+ BLB0 BL3 BLB7 BLB2 BL7 BLB6 BL6 BLB5 BL2 BLB1 BL0 sram_2w16b
x8 WL14 VDD VSS WL15 BLB10 BL9 BLB8 BL13 BL12 BLB12 BLB9 BL11 BL10 BL14 BLB14 BLB13 BLB15 BL15 BLB11 BL8 BL5 BLB4 BL1 BL4 BLB3
+ BLB0 BL3 BLB7 BLB2 BL7 BLB6 BL6 BLB5 BL2 BLB1 BL0 sram_2w16b
.ends

* expanding   symbol:  decoder.sym # of pins=6
** sym_path: /home/take/Design/tr10_sram/sram/decoder.sym
** sch_path: /home/take/Design/tr10_sram/sram/decoder.sch
.subckt decoder VDD VSS WL0 WLE A0 WL1
*.PININFO VDD:B VSS:B WLE:I WL0:O WL1:O A0:I
MXM7 A0B A0 VDD VDD PMOS w=6.8u l=1u
MXM8 A0B A0 VSS VSS NMOS w=3.4u l=1u
MXM9 net2 WLE VDD VDD PMOS w=6.8u l=1u
MXM10 net1 WLE VSS VSS NMOS w=6.8u l=1u
MXM11 net2 A0B net1 VSS NMOS w=6.8u l=1u
MXM12 net2 A0B VDD VDD PMOS w=6.8u l=1u
MXM13 WL0 net2 VDD VDD PMOS w=6.8u l=1u
MXM14 WL0 net2 VSS VSS NMOS w=3.4u l=1u
MXM15 net4 WLE VDD VDD PMOS w=6.8u l=1u
MXM16 net3 WLE VSS VSS NMOS w=6.8u l=1u
MXM17 net4 A0 net3 VSS NMOS w=6.8u l=1u
MXM18 net4 A0 VDD VDD PMOS w=6.8u l=1u
MXM19 WL1 net4 VDD VDD PMOS w=6.8u l=1u
MXM20 WL1 net4 VSS VSS NMOS w=3.4u l=1u
.ends

* expanding   symbol:  sram_2w16b.sym # of pins=36
** sym_path: /home/take/Design/tr10_sram/sram/sram_2w16b.sym
** sch_path: /home/take/Design/tr10_sram/sram/sram_2w16b.sch
.subckt sram_2w16b WL0 VDD VSS WL1 BLB10 BL9 BLB8 BL13 BL12 BLB12 BLB9 BL11 BL10 BL14 BLB14 BLB13 BLB15 BL15 BLB11 BL8 BL5 BLB4
+ BL1 BL4 BLB3 BLB0 BL3 BLB7 BLB2 BL7 BLB6 BL6 BLB5 BL2 BLB1 BL0
*.PININFO VDD:B VSS:B WL0:I WL1:I BL0:B BLB0:B BL1:B BLB1:B BL2:B BLB2:B BL3:B BLB3:B BL4:B BLB4:B BL5:B BLB5:B BL6:B BLB6:B BL7:B
*+ BLB7:B BL8:B BLB8:B BL9:B BLB9:B BL10:B BLB10:B BL11:B BLB11:B BL12:B BLB12:B BL13:B BLB13:B BL14:B BLB14:B BL15:B BLB15:B
x1 BL0 BLB0 WL1 VDD VSS sram6t_tr10
x2 BL0 BLB0 WL0 VDD VSS sram6t_tr10
x3 BL1 BLB1 WL0 VDD VSS sram6t_tr10
x4 BL1 BLB1 WL1 VDD VSS sram6t_tr10
x5 BL2 BLB2 WL1 VDD VSS sram6t_tr10
x6 BL2 BLB2 WL0 VDD VSS sram6t_tr10
x7 BL3 BLB3 WL0 VDD VSS sram6t_tr10
x8 BL3 BLB3 WL1 VDD VSS sram6t_tr10
x9 BL4 BLB4 WL1 VDD VSS sram6t_tr10
x10 BL4 BLB4 WL0 VDD VSS sram6t_tr10
x11 BL5 BLB5 WL0 VDD VSS sram6t_tr10
x12 BL5 BLB5 WL1 VDD VSS sram6t_tr10
x13 BL6 BLB6 WL1 VDD VSS sram6t_tr10
x14 BL6 BLB6 WL0 VDD VSS sram6t_tr10
x15 BL7 BLB7 WL0 VDD VSS sram6t_tr10
x16 BL7 BLB7 WL1 VDD VSS sram6t_tr10
x17 BL8 BLB8 WL1 VDD VSS sram6t_tr10
x18 BL8 BLB8 WL0 VDD VSS sram6t_tr10
x19 BL9 BLB9 WL0 VDD VSS sram6t_tr10
x20 BL9 BLB9 WL1 VDD VSS sram6t_tr10
x21 BL10 BLB10 WL1 VDD VSS sram6t_tr10
x22 BL10 BLB10 WL0 VDD VSS sram6t_tr10
x23 BL11 BLB11 WL0 VDD VSS sram6t_tr10
x24 BL11 BLB11 WL1 VDD VSS sram6t_tr10
x25 BL12 BLB12 WL1 VDD VSS sram6t_tr10
x26 BL12 BLB12 WL0 VDD VSS sram6t_tr10
x27 BL13 BLB13 WL0 VDD VSS sram6t_tr10
x28 BL13 BLB13 WL1 VDD VSS sram6t_tr10
x29 BL14 BLB14 WL1 VDD VSS sram6t_tr10
x30 BL14 BLB14 WL0 VDD VSS sram6t_tr10
x31 BL15 BLB15 WL0 VDD VSS sram6t_tr10
x32 BL15 BLB15 WL1 VDD VSS sram6t_tr10
.ends

* expanding   symbol:  sram6t_tr10.sym # of pins=5
** sym_path: /home/take/Design/tr10_sram/sram/sram6t_tr10.sym
** sch_path: /home/take/Design/tr10_sram/sram/sram6t_tr10.sch
.subckt sram6t_tr10 BL BLB WL VDD VSS
*.PININFO BL:B BLB:B WL:I VDD:B VSS:B
MXM1 net1 net2 VDD VDD PMOS w=3.4u l=1u
MXM2 net2 net1 VDD VDD PMOS w=3.4u l=1u
MXM4 net2 net1 VSS VSS NMOS w=6.8u l=1u
MXM3 net1 net2 VSS VSS NMOS w=6.8u l=1u
MXM5 BL WL net1 VSS NMOS w=5.1u l=1u
MXM6 BLB WL net2 VSS NMOS w=5.1u l=1u
.ends
