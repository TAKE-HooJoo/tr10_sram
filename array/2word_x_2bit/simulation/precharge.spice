** sch_path: /home/take/Design/tr10_sram/array/2word_x_2bit/precharge.sch
.subckt precharge VDD VSS PCB EQEN BL0 BLB0 BL1 BLB1
*.PININFO VDD:B VSS:B PCB:I EQEN:I BL0:B BLB0:B BL1:B BLB1:B
MXM9 BL0 PCB VDD VDD PMOS w=3.4u l=1u
MXM10 BLB0 PCB VDD VDD PMOS w=3.4u l=1u
MXM11 BL0 EQEN BLB0 VSS NMOS w=3.4u l=1u
MXM12 BL1 PCB VDD VDD PMOS w=3.4u l=1u
MXM13 BLB1 PCB VDD VDD PMOS w=3.4u l=1u
MXM14 BL1 EQEN BLB1 VSS NMOS w=3.4u l=1u
.ends
