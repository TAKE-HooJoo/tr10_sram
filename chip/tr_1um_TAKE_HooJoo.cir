* TR-1um MPW SRAM TEG - final LVS reference netlist
* PAD mapping confirmed from tr_1um_TAKE_HooJoo_SRAM_UPDATED.gds extraction:
* P1=WE P2=WLE P3=PCB P4=A0 P5=DIN0 P6=DIN1 P7=DOUT0
* P9=DOUT1 P10=DOUT2 P11=DOUT3 P12=DOUT4 P13=DOUT5 P14=DOUT6 P15=DOUT7
* VDD=VDD VSS=VSS

.subckt tr_1um_TAKE_HooJoo P1 P2 P3 P4 P5 P6 P7 VSS VDD P15 P14 P13 P12 P11 P10 P9
*.PININFO P1:B P2:B P3:B P4:B P5:B P6:B P7:B VSS:B VDD:B P15:B P14:B P13:B P12:B P11:B P10:B P9:B

* MPW frame
XFRAME P1 VDD P2 P15 P14 P3 P4 P13 P5 P12 P6 P11 P10 P7 P9 VSS OSS_FRAME

* SRAM TEG
* sram_teg_top port order:
* VDD WLE VSS A0 WE DIN0 DIN1 DOUT0 DOUT1 DOUT2 DOUT3 DOUT4 DOUT5 DOUT6 DOUT7 PCB
XSRAM VDD P2 VSS P4 P1 P5 P6 P7 P9 P10 P11 P12 P13 P14 P15 P3 sram_teg_top

.ends tr_1um_TAKE_HooJoo

* expanding   symbol:  OSS_FRAME.sym # of pins=16
** sym_path: /Users/okamura/Dropbox/91_OpenPDK/WorkDir/OSS_FRAME.sym
** sch_path: /Users/okamura/Dropbox/91_OpenPDK/WorkDir/OSS_FRAME.sch
.subckt OSS_FRAME P1 VDD P2 P15 P14 P3 P4 P13 P5 P12 P6 P11 P10 P7 P9 VSS
*.PININFO P1:B P2:B P3:B P4:B P5:B P6:B P7:B VSS:B VDD:B P15:B P14:B P13:B P12:B P11:B P10:B P9:B
x1 VDD P1 VSS OSS_ESD_5V_ANA
x2 VDD VSS OSS_ESD_5V_VDD
x3 VDD VSS OSS_ESD_5V_VSS
x4 VDD P2 VSS OSS_ESD_5V_ANA
x5 VDD P3 VSS OSS_ESD_5V_ANA
x6 VDD P4 VSS OSS_ESD_5V_ANA
x7 VDD P5 VSS OSS_ESD_5V_ANA
x8 VDD P6 VSS OSS_ESD_5V_ANA
x9 VDD P7 VSS OSS_ESD_5V_ANA
x10 VDD P15 VSS OSS_ESD_5V_ANA
x11 VDD P14 VSS OSS_ESD_5V_ANA
x12 VDD P13 VSS OSS_ESD_5V_ANA
x13 VDD P12 VSS OSS_ESD_5V_ANA
x14 VDD P11 VSS OSS_ESD_5V_ANA
x15 VDD P10 VSS OSS_ESD_5V_ANA
x16 VDD P9 VSS OSS_ESD_5V_ANA
.ends

* expanding   symbol:  OSS_ESD_5V_ANA.sym # of pins=4
** sym_path: /Users/okamura/Dropbox/91_OpenPDK/WorkDir/OSS_ESD_5V_ANA.sym
** sch_path: /Users/okamura/Dropbox/91_OpenPDK/WorkDir/OSS_ESD_5V_ANA.sch
.subckt OSS_ESD_5V_ANA VDD PAD VSS
*.PININFO PAD:B VDD:B VSS:B
MXM1 PAD VDD VDD VDD PMOS w=500u l=2u
MXM2 PAD VSS VSS VSS NMOSE w=500u l=2u
.ends

* expanding   symbol:  OSS_ESD_5V_VDD.sym # of pins=3
** sym_path: /Users/okamura/Dropbox/91_OpenPDK/WorkDir/OSS_ESD_5V_VDD.sym
** sch_path: /Users/okamura/Dropbox/91_OpenPDK/WorkDir/OSS_ESD_5V_VDD.sch
.subckt OSS_ESD_5V_VDD VDD VSS
*.PININFO VDD:B VSS:B
MXM1 VDD VDD VDD VDD PMOS w=500u l=2u
MXM2 VDD VSS VSS VSS NMOSE w=500u l=2u
.ends

* expanding   symbol:  OSS_ESD_5V_VSS.sym # of pins=3
** sym_path: /Users/okamura/Dropbox/91_OpenPDK/WorkDir/OSS_ESD_5V_VSS.sym
** sch_path: /Users/okamura/Dropbox/91_OpenPDK/WorkDir/OSS_ESD_5V_VSS.sch
.subckt OSS_ESD_5V_VSS VDD VSS
*.PININFO VSS:B VDD:B
MXM1 VSS VDD VDD VDD PMOS w=500u l=2u
MXM2 VSS VSS VSS VSS NMOSE w=500u l=2u
.ends

** sch_path: /home/take/Design/tr10_sram/sram/sram_teg_top.sch
.subckt sram_teg_top VDD WLE VSS A0 WE DIN0 DIN1 DOUT0 DOUT1 DOUT2 DOUT3 DOUT4 DOUT5 DOUT6 DOUT7 PCB
*.PININFO VDD:B WLE:I VSS:B A0:I WE:I DIN0:I DIN1:I DOUT0:O DOUT1:O DOUT2:O DOUT3:O DOUT4:O DOUT5:O DOUT6:O DOUT7:O PCB:I
x1 WLE DOUT0 VDD PCB WE DIN0 DOUT1 DIN1 A0 VSS sram_2w2b_top
x2 DIN0 VDD WLE WE VSS A0 DIN1 PCB DOUT2 DOUT3 sram_2w16b_top
x3 WLE DOUT4 VDD PCB WE DIN0 DOUT5 DIN1 A0 VSS sram_16w2b_top
x4 WE VDD WLE VSS A0 DIN0 DIN1 PCB DOUT6 DOUT7 sram_16w16b_top
.ends

* expanding   symbol:  sram_2w2b_top.sym # of pins=10
** sym_path: /home/take/Design/tr10_sram/sram/sram_2w2b_top.sym
** sch_path: /home/take/Design/tr10_sram/sram/sram_2w2b_top.sch
.subckt sram_2w2b_top WLE DOUT0 VDD PCB WE DIN0 DOUT1 DIN1 A0 VSS
*.PININFO VDD:B WLE:I DOUT0:O VSS:B A0:I WE:I DIN0:I DIN1:I PCB:I DOUT1:O
x1 WL0 BL0 VDD BL1 BLB1 WL1 BLB0 VSS sram_2w2b
x2 VDD VSS WL0 WLE A0 WL1 decoder
x3 DIN0 VDD BL0 BLB0 VSS DIN1 BL1 WE BLB1 WEB write_driver
x4 VDD VSS PCB EQEN BL0 BLB0 BL1 BLB1 precharge
x5 VDD VSS BLB0 BLB1 DOUT0 DOUT1 read_buffer
MXM1 WEB WE VSS VSS NMOS w=3.4u l=1u
MXM2 WEB WE VDD VDD PMOS w=6.8u l=1u
MXM3 EQEN PCB VSS VSS NMOS w=3.4u l=1u
MXM4 EQEN PCB VDD VDD PMOS w=6.8u l=1u
.ends

* expanding   symbol:  sram_2w16b_top.sym # of pins=10
** sym_path: /home/take/Design/tr10_sram/sram/sram_2w16b_top.sym
** sch_path: /home/take/Design/tr10_sram/sram/sram_2w16b_top.sch
.subckt sram_2w16b_top DIN0 VDD WLE WE VSS A0 DIN15 PCB DOUT0 DOUT15
*.PININFO VDD:B WLE:I DOUT0:O VSS:B A0:I WE:I DIN0:I PCB:I DOUT15:O DIN15:I
x2 VDD VSS WL0 WLE A0 WL1 decoder
x4 VDD VSS PCB EQEN BL0 BLB0 BL15 BLB15 precharge
x5 VDD VSS BLB0 BLB15 DOUT0 DOUT15 read_buffer
MXM1 WEB WE VSS VSS NMOS w=3.4u l=1u
MXM2 WEB WE VDD VDD PMOS w=6.8u l=1u
MXM3 EQEN PCB VSS VSS NMOS w=3.4u l=1u
MXM4 EQEN PCB VDD VDD PMOS w=6.8u l=1u
x1 WL0 VDD VSS WL1 BLB10 BL9 BLB8 BL13 BL12 BLB12 BLB9 BL11 BL10 BL14 BLB14 BLB13 BLB15 BL15 BLB11 BL8 BL5 BLB4 BL1 BL4 BLB3 BLB0
+ BL3 BLB7 BLB2 BL7 BLB6 BL6 BLB5 BL2 BLB1 BL0 sram_2w16b
x12 DIN0 VDD BL0 BLB0 VSS VSS BL1 WE BLB1 WEB write_driver
x13 VSS VDD BL2 BLB2 VSS VSS BL3 WE BLB3 WEB write_driver
x14 VSS VDD BL4 BLB4 VSS VSS BL5 WE BLB5 WEB write_driver
x15 VSS VDD BL6 BLB6 VSS VSS BL7 WE BLB7 WEB write_driver
x16 VSS VDD BL8 BLB8 VSS VSS BL9 WE BLB9 WEB write_driver
x17 VSS VDD BL10 BLB10 VSS VSS BL11 WE BLB11 WEB write_driver
x18 VSS VDD BL12 BLB12 VSS VSS BL13 WE BLB13 WEB write_driver
x19 VSS VDD BL14 BLB14 VSS DIN15 BL15 WE BLB15 WEB write_driver
.ends

* expanding   symbol:  sram_16w2b_top.sym # of pins=10
** sym_path: /home/take/Design/tr10_sram/sram/sram_16w2b_top.sym
** sch_path: /home/take/Design/tr10_sram/sram/sram_16w2b_top.sch
.subckt sram_16w2b_top WLE DOUT0 VDD PCB WE DIN0 DOUT1 DIN1 A0 VSS
*.PININFO VDD:B WLE:I DOUT0:O VSS:B A0:I WE:I DIN0:I DIN1:I PCB:I DOUT1:O
x2 VDD VSS WL0 WLE A0 net1 decoder
x3 DIN0 VDD BL0 BLB0 VSS DIN1 BL1 WE BLB1 WEB write_driver
x4 VDD VSS PCB EQEN BL0 BLB0 BL1 BLB1 precharge
x5 VDD VSS BLB0 BLB1 DOUT0 DOUT1 read_buffer
MXM1 WEB WE VSS VSS NMOS w=3.4u l=1u
MXM2 WEB WE VDD VDD PMOS w=6.8u l=1u
MXM3 EQEN PCB VSS VSS NMOS w=3.4u l=1u
MXM4 EQEN PCB VDD VDD PMOS w=6.8u l=1u
x1 BL0 VDD WL0 VSS BL1 VSS VSS BLB1 VSS BLB0 VSS VSS VSS VSS VSS VSS VSS VSS VSS VSS WL15 VSS sram_16w2b
x6 VDD VSS net2 WLE A0 net3 decoder
x7 VDD VSS net4 WLE A0 net5 decoder
x8 VDD VSS net6 WLE A0 net7 decoder
x9 VDD VSS net8 WLE A0 net9 decoder
x10 VDD VSS net10 WLE A0 net11 decoder
x11 VDD VSS net12 WLE A0 net13 decoder
x12 VDD VSS net14 WLE A0 WL15 decoder
.ends

* expanding   symbol:  sram_16w16b_top.sym # of pins=10
** sym_path: /home/take/Design/tr10_sram/sram/sram_16w16b_top.sym
** sch_path: /home/take/Design/tr10_sram/sram/sram_16w16b_top.sch
.subckt sram_16w16b_top WE VDD WLE VSS A0 DIN0 DIN15 PCB DOUT0 DOUT15
*.PININFO VDD:B WLE:I DOUT0:O VSS:B A0:I WE:I DIN0:I PCB:I DOUT15:O DIN15:I
x4 VDD VSS PCB EQEN BL0 BLB0 BL15 BLB15 precharge
x5 VDD VSS BLB0 BLB15 DOUT0 DOUT15 read_buffer
MXM1 WEB WE VSS VSS NMOS w=3.4u l=1u
MXM2 WEB WE VDD VDD PMOS w=6.8u l=1u
MXM3 EQEN PCB VSS VSS NMOS w=3.4u l=1u
MXM4 EQEN PCB VDD VDD PMOS w=6.8u l=1u
x12 DIN0 VDD BL0 BLB0 VSS VSS BL1 WE BLB1 WEB write_driver
x13 VSS VDD BL2 BLB2 VSS VSS BL3 WE BLB3 WEB write_driver
x14 VSS VDD BL4 BLB4 VSS VSS BL5 WE BLB5 WEB write_driver
x15 VSS VDD BL6 BLB6 VSS VSS BL7 WE BLB7 WEB write_driver
x16 VSS VDD BL8 BLB8 VSS VSS BL9 WE BLB9 WEB write_driver
x17 VSS VDD BL10 BLB10 VSS VSS BL11 WE BLB11 WEB write_driver
x18 VSS VDD BL12 BLB12 VSS VSS BL13 WE BLB13 WEB write_driver
x19 VSS VDD BL14 BLB14 VSS DIN15 BL15 WE BLB15 WEB write_driver
x1 VDD VSS BLB10 BL9 BLB8 BL13 BL12 BLB12 BLB9 BL11 BL10 BL14 BLB14 BLB13 BLB15 BL15 BLB11 BL8 BL5 BLB4 BL1 BL4 BLB3 BLB0 BL3 BLB7
+ BLB2 BL7 BLB6 BL6 BLB5 BL2 BLB1 BL0 VSS VSS VSS VSS VSS WL15 VSS VSS VSS VSS VSS WL0 VSS VSS VSS VSS sram_16w16b
x3 VDD VSS WL0 WLE A0 net1 decoder
x6 VDD VSS net2 WLE A0 net3 decoder
x7 VDD VSS net4 WLE A0 net5 decoder
x8 VDD VSS net6 WLE A0 net7 decoder
x9 VDD VSS net8 WLE A0 net9 decoder
x10 VDD VSS net10 WLE A0 net11 decoder
x11 VDD VSS net12 WLE A0 net13 decoder
x20 VDD VSS net14 WLE A0 WL15 decoder
.ends

* expanding   symbol:  sram_2w2b.sym # of pins=8
** sym_path: /home/take/Design/tr10_sram/sram/sram_2w2b.sym
** sch_path: /home/take/Design/tr10_sram/sram/sram_2w2b.sch
.subckt sram_2w2b WL0 BL0 VDD BL1 BLB1 WL1 BLB0 VSS
*.PININFO VDD:B VSS:B BL0:B BLB0:B BL1:B BLB1:B WL0:I WL1:I
x1 BL0 BLB0 WL0 VDD VSS sram6t_tr10
x2 BL1 BLB1 WL0 VDD VSS sram6t_tr10
x3 BL0 BLB0 WL1 VDD VSS sram6t_tr10
x4 BL1 BLB1 WL1 VDD VSS sram6t_tr10
.ends

* expanding   symbol:  decoder.sym # of pins=6
** sym_path: /home/take/Design/tr10_sram/sram/decoder.sym
** sch_path: /home/take/Design/tr10_sram/sram/decoder.sch
.subckt decoder VDD VSS WL0 WLE A0 WL1
*.PININFO VDD:B VSS:B WLE:I WL0:O WL1:O A0:I
MXM7 A0B A0 VDD VDD PMOS w=6.8u l=1u
MXM8 A0B A0 VSS VSS NMOS w=3.4u l=1u
MXM9 net2 WLE VDD VDD PMOS w=6.8u l=1u
MXM10 net1 WLE VSS VSS NMOS w=6.8u l=1u
MXM11 net2 A0B net1 VSS NMOS w=6.8u l=1u
MXM12 net2 A0B VDD VDD PMOS w=6.8u l=1u
MXM13 WL0 net2 VDD VDD PMOS w=6.8u l=1u
MXM14 WL0 net2 VSS VSS NMOS w=3.4u l=1u
MXM15 net4 WLE VDD VDD PMOS w=6.8u l=1u
MXM16 net3 WLE VSS VSS NMOS w=6.8u l=1u
MXM17 net4 A0 net3 VSS NMOS w=6.8u l=1u
MXM18 net4 A0 VDD VDD PMOS w=6.8u l=1u
MXM19 WL1 net4 VDD VDD PMOS w=6.8u l=1u
MXM20 WL1 net4 VSS VSS NMOS w=3.4u l=1u
.ends

* expanding   symbol:  write_driver.sym # of pins=10
** sym_path: /home/take/Design/tr10_sram/sram/write_driver.sym
** sch_path: /home/take/Design/tr10_sram/sram/write_driver.sch
.subckt write_driver DIN0 VDD BL0 BLB0 VSS DIN1 BL1 WE BLB1 WEB
*.PININFO DIN0:I DIN1:I WE:I WEB:I BL0:B BLB0:B BL1:B BLB1:B VDD:B VSS:B
MXM15 DIN0B DIN0 VDD VDD PMOS w=6.8u l=1u
MXM16 DIN0B DIN0 VSS VSS NMOS w=3.4u l=1u
MXM7 BL0 WE DIN0 VSS NMOS w=5.2u l=1u
MXM8 DIN0 WEB BL0 VDD PMOS w=6.8u l=1u
MXM1 BLB0 WE DIN0B VSS NMOS w=5.2u l=1u
MXM2 DIN0B WEB BLB0 VDD PMOS w=6.8u l=1u
MXM3 DIN1B DIN1 VDD VDD PMOS w=6.8u l=1u
MXM4 DIN1B DIN1 VSS VSS NMOS w=3.4u l=1u
MXM5 BL1 WE DIN1 VSS NMOS w=5.2u l=1u
MXM6 DIN1 WEB BL1 VDD PMOS w=6.8u l=1u
MXM9 BLB1 WE DIN1B VSS NMOS w=5.2u l=1u
MXM10 DIN1B WEB BLB1 VDD PMOS w=6.8u l=1u
.ends

* expanding   symbol:  precharge.sym # of pins=8
** sym_path: /home/take/Design/tr10_sram/sram/precharge.sym
** sch_path: /home/take/Design/tr10_sram/sram/precharge.sch
.subckt precharge VDD VSS PCB EQEN BL0 BLB0 BL1 BLB1
*.PININFO VDD:B VSS:B PCB:I EQEN:I BL0:B BLB0:B BL1:B BLB1:B
MXM9 BL0 PCB VDD VDD PMOS w=3.4u l=1u
MXM10 BLB0 PCB VDD VDD PMOS w=3.4u l=1u
MXM11 BL0 EQEN BLB0 VSS NMOS w=3.4u l=1u
MXM12 BL1 PCB VDD VDD PMOS w=3.4u l=1u
MXM13 BLB1 PCB VDD VDD PMOS w=3.4u l=1u
MXM14 BL1 EQEN BLB1 VSS NMOS w=3.4u l=1u
.ends

* expanding   symbol:  read_buffer.sym # of pins=6
** sym_path: /home/take/Design/tr10_sram/sram/read_buffer.sym
** sch_path: /home/take/Design/tr10_sram/sram/read_buffer.sch
.subckt read_buffer VDD VSS BLB0 BLB1 DOUT0 DOUT1
*.PININFO VDD:B VSS:B BLB0:I BLB1:I DOUT0:O DOUT1:O
MXM15 DOUT0 BLB0 VDD VDD PMOS w=6.8u l=1u
MXM16 DOUT0 BLB0 VSS VSS NMOS w=3.4u l=1u
MXM1 DOUT1 BLB1 VDD VDD PMOS w=6.8u l=1u
MXM2 DOUT1 BLB1 VSS VSS NMOS w=3.4u l=1u
.ends

* expanding   symbol:  sram_2w16b.sym # of pins=36
** sym_path: /home/take/Design/tr10_sram/sram/sram_2w16b.sym
** sch_path: /home/take/Design/tr10_sram/sram/sram_2w16b.sch
.subckt sram_2w16b WL0 VDD VSS WL1 BLB10 BL9 BLB8 BL13 BL12 BLB12 BLB9 BL11 BL10 BL14 BLB14 BLB13 BLB15 BL15 BLB11 BL8 BL5 BLB4
+ BL1 BL4 BLB3 BLB0 BL3 BLB7 BLB2 BL7 BLB6 BL6 BLB5 BL2 BLB1 BL0
*.PININFO VDD:B VSS:B WL0:I WL1:I BL0:B BLB0:B BL1:B BLB1:B BL2:B BLB2:B BL3:B BLB3:B BL4:B BLB4:B BL5:B BLB5:B BL6:B BLB6:B BL7:B
*+ BLB7:B BL8:B BLB8:B BL9:B BLB9:B BL10:B BLB10:B BL11:B BLB11:B BL12:B BLB12:B BL13:B BLB13:B BL14:B BLB14:B BL15:B BLB15:B
x1 BL0 BLB0 WL1 VDD VSS sram6t_tr10
x2 BL0 BLB0 WL0 VDD VSS sram6t_tr10
x3 BL1 BLB1 WL0 VDD VSS sram6t_tr10
x4 BL1 BLB1 WL1 VDD VSS sram6t_tr10
x5 BL2 BLB2 WL1 VDD VSS sram6t_tr10
x6 BL2 BLB2 WL0 VDD VSS sram6t_tr10
x7 BL3 BLB3 WL0 VDD VSS sram6t_tr10
x8 BL3 BLB3 WL1 VDD VSS sram6t_tr10
x9 BL4 BLB4 WL1 VDD VSS sram6t_tr10
x10 BL4 BLB4 WL0 VDD VSS sram6t_tr10
x11 BL5 BLB5 WL0 VDD VSS sram6t_tr10
x12 BL5 BLB5 WL1 VDD VSS sram6t_tr10
x13 BL6 BLB6 WL1 VDD VSS sram6t_tr10
x14 BL6 BLB6 WL0 VDD VSS sram6t_tr10
x15 BL7 BLB7 WL0 VDD VSS sram6t_tr10
x16 BL7 BLB7 WL1 VDD VSS sram6t_tr10
x17 BL8 BLB8 WL1 VDD VSS sram6t_tr10
x18 BL8 BLB8 WL0 VDD VSS sram6t_tr10
x19 BL9 BLB9 WL0 VDD VSS sram6t_tr10
x20 BL9 BLB9 WL1 VDD VSS sram6t_tr10
x21 BL10 BLB10 WL1 VDD VSS sram6t_tr10
x22 BL10 BLB10 WL0 VDD VSS sram6t_tr10
x23 BL11 BLB11 WL0 VDD VSS sram6t_tr10
x24 BL11 BLB11 WL1 VDD VSS sram6t_tr10
x25 BL12 BLB12 WL1 VDD VSS sram6t_tr10
x26 BL12 BLB12 WL0 VDD VSS sram6t_tr10
x27 BL13 BLB13 WL0 VDD VSS sram6t_tr10
x28 BL13 BLB13 WL1 VDD VSS sram6t_tr10
x29 BL14 BLB14 WL1 VDD VSS sram6t_tr10
x30 BL14 BLB14 WL0 VDD VSS sram6t_tr10
x31 BL15 BLB15 WL0 VDD VSS sram6t_tr10
x32 BL15 BLB15 WL1 VDD VSS sram6t_tr10
.ends

* expanding   symbol:  sram_16w2b.sym # of pins=22
** sym_path: /home/take/Design/tr10_sram/sram/sram_16w2b.sym
** sch_path: /home/take/Design/tr10_sram/sram/sram_16w2b.sch
.subckt sram_16w2b BL0 VDD WL0 WL8 BL1 VSS WL1 BLB1 WL9 BLB0 WL2 WL10 WL3 WL11 WL4 WL12 WL5 WL13 WL6 WL14 WL15 WL7
*.PININFO VDD:B BL0:B BLB0:B BL1:B BLB1:B WL0:I WL1:I WL2:I WL3:I WL4:I WL5:I WL6:I WL7:I VSS:B WL8:I WL9:I WL10:I WL11:I WL12:I
*+ WL13:I WL14:I WL15:I
x17 BL0 BLB0 WL0 VDD VSS sram6t_tr10
x3 BL1 BLB1 WL0 VDD VSS sram6t_tr10
x1 BL0 BLB0 WL1 VDD VSS sram6t_tr10
x2 BL1 BLB1 WL1 VDD VSS sram6t_tr10
x6 BL0 BLB0 WL2 VDD VSS sram6t_tr10
x7 BL1 BLB1 WL2 VDD VSS sram6t_tr10
x8 BL0 BLB0 WL3 VDD VSS sram6t_tr10
x18 BL1 BLB1 WL3 VDD VSS sram6t_tr10
x9 BL0 BLB0 WL4 VDD VSS sram6t_tr10
x10 BL1 BLB1 WL4 VDD VSS sram6t_tr10
x11 BL0 BLB0 WL5 VDD VSS sram6t_tr10
x12 BL1 BLB1 WL5 VDD VSS sram6t_tr10
x13 BL0 BLB0 WL6 VDD VSS sram6t_tr10
x14 BL1 BLB1 WL6 VDD VSS sram6t_tr10
x15 BL0 BLB0 WL7 VDD VSS sram6t_tr10
x16 BL1 BLB1 WL7 VDD VSS sram6t_tr10
x4 BL0 BLB0 WL8 VDD VSS sram6t_tr10
x5 BL1 BLB1 WL8 VDD VSS sram6t_tr10
x19 BL0 BLB0 WL9 VDD VSS sram6t_tr10
x20 BL1 BLB1 WL9 VDD VSS sram6t_tr10
x21 BL0 BLB0 WL10 VDD VSS sram6t_tr10
x22 BL1 BLB1 WL10 VDD VSS sram6t_tr10
x23 BL0 BLB0 WL11 VDD VSS sram6t_tr10
x24 BL1 BLB1 WL11 VDD VSS sram6t_tr10
x25 BL0 BLB0 WL12 VDD VSS sram6t_tr10
x26 BL1 BLB1 WL12 VDD VSS sram6t_tr10
x27 BL0 BLB0 WL13 VDD VSS sram6t_tr10
x28 BL1 BLB1 WL13 VDD VSS sram6t_tr10
x29 BL0 BLB0 WL14 VDD VSS sram6t_tr10
x30 BL1 BLB1 WL14 VDD VSS sram6t_tr10
x31 BL0 BLB0 WL15 VDD VSS sram6t_tr10
x32 BL1 BLB1 WL15 VDD VSS sram6t_tr10
.ends

* expanding   symbol:  sram_16w16b.sym # of pins=50
** sym_path: /home/take/Design/tr10_sram/sram/sram_16w16b.sym
** sch_path: /home/take/Design/tr10_sram/sram/sram_16w16b.sch
.subckt sram_16w16b VDD VSS BLB10 BL9 BLB8 BL13 BL12 BLB12 BLB9 BL11 BL10 BL14 BLB14 BLB13 BLB15 BL15 BLB11 BL8 BL5 BLB4 BL1 BL4
+ BLB3 BLB0 BL3 BLB7 BLB2 BL7 BLB6 BL6 BLB5 BL2 BLB1 BL0 WL14 WL12 WL10 WL8 WL13 WL15 WL11 WL9 WL6 WL4 WL2 WL0 WL5 WL7 WL3 WL1
*.PININFO WL0:I WL1:I WL2:I WL3:I WL4:I WL5:I WL6:I WL7:I WL8:I WL9:I WL10:I WL11:I WL12:I WL13:I WL14:I WL15:I VDD:B VSS:B
*+ BLB10:B BL9:B BLB8:B BL13:B BL12:B BLB12:B BLB9:B BL11:B BL10:B BL14:B BLB14:B BLB13:B BLB15:B BL15:B BLB11:B BL8:B BL5:B BLB4:B BL1:B
*+ BL4:B BLB3:B BLB0:B BL3:B BLB7:B BLB2:B BL7:B BLB6:B BL6:B BLB5:B BL2:B BLB1:B BL0:B
x1 WL0 VDD VSS WL1 BLB10 BL9 BLB8 BL13 BL12 BLB12 BLB9 BL11 BL10 BL14 BLB14 BLB13 BLB15 BL15 BLB11 BL8 BL5 BLB4 BL1 BL4 BLB3 BLB0
+ BL3 BLB7 BLB2 BL7 BLB6 BL6 BLB5 BL2 BLB1 BL0 sram_2w16b
x2 WL2 VDD VSS WL3 BLB10 BL9 BLB8 BL13 BL12 BLB12 BLB9 BL11 BL10 BL14 BLB14 BLB13 BLB15 BL15 BLB11 BL8 BL5 BLB4 BL1 BL4 BLB3 BLB0
+ BL3 BLB7 BLB2 BL7 BLB6 BL6 BLB5 BL2 BLB1 BL0 sram_2w16b
x3 WL4 VDD VSS WL5 BLB10 BL9 BLB8 BL13 BL12 BLB12 BLB9 BL11 BL10 BL14 BLB14 BLB13 BLB15 BL15 BLB11 BL8 BL5 BLB4 BL1 BL4 BLB3 BLB0
+ BL3 BLB7 BLB2 BL7 BLB6 BL6 BLB5 BL2 BLB1 BL0 sram_2w16b
x4 WL6 VDD VSS WL7 BLB10 BL9 BLB8 BL13 BL12 BLB12 BLB9 BL11 BL10 BL14 BLB14 BLB13 BLB15 BL15 BLB11 BL8 BL5 BLB4 BL1 BL4 BLB3 BLB0
+ BL3 BLB7 BLB2 BL7 BLB6 BL6 BLB5 BL2 BLB1 BL0 sram_2w16b
x5 WL8 VDD VSS WL9 BLB10 BL9 BLB8 BL13 BL12 BLB12 BLB9 BL11 BL10 BL14 BLB14 BLB13 BLB15 BL15 BLB11 BL8 BL5 BLB4 BL1 BL4 BLB3 BLB0
+ BL3 BLB7 BLB2 BL7 BLB6 BL6 BLB5 BL2 BLB1 BL0 sram_2w16b
x6 WL10 VDD VSS WL11 BLB10 BL9 BLB8 BL13 BL12 BLB12 BLB9 BL11 BL10 BL14 BLB14 BLB13 BLB15 BL15 BLB11 BL8 BL5 BLB4 BL1 BL4 BLB3
+ BLB0 BL3 BLB7 BLB2 BL7 BLB6 BL6 BLB5 BL2 BLB1 BL0 sram_2w16b
x7 WL12 VDD VSS WL13 BLB10 BL9 BLB8 BL13 BL12 BLB12 BLB9 BL11 BL10 BL14 BLB14 BLB13 BLB15 BL15 BLB11 BL8 BL5 BLB4 BL1 BL4 BLB3
+ BLB0 BL3 BLB7 BLB2 BL7 BLB6 BL6 BLB5 BL2 BLB1 BL0 sram_2w16b
x8 WL14 VDD VSS WL15 BLB10 BL9 BLB8 BL13 BL12 BLB12 BLB9 BL11 BL10 BL14 BLB14 BLB13 BLB15 BL15 BLB11 BL8 BL5 BLB4 BL1 BL4 BLB3
+ BLB0 BL3 BLB7 BLB2 BL7 BLB6 BL6 BLB5 BL2 BLB1 BL0 sram_2w16b
.ends

* expanding   symbol:  /home/take/Design/tr10_sram/cell/sram6t_tr10.sym # of pins=5
** sym_path: /home/take/Design/tr10_sram/cell/sram6t_tr10.sym
** sch_path: /home/take/Design/tr10_sram/cell/sram6t_tr10.sch
.subckt sram6t_tr10 BL BLB WL VDD VSS
*.PININFO BL:B BLB:B WL:I VDD:B VSS:B
MXM1 Q QB VDD VDD PMOS w=3.4u l=1u
MXM2 QB Q VDD VDD PMOS w=3.4u l=1u
MXM4 QB Q VSS VSS NMOS w=6.8u l=1u
MXM3 Q QB VSS VSS NMOS w=6.8u l=1u
MXM5 BL WL Q VSS NMOS w=5.1u l=1u
MXM6 BLB WL QB VSS NMOS w=5.1u l=1u
.ends
