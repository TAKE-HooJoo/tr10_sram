** sch_path: /home/take/Design/tr10_sram/Deliverables/sram_2w2b_top.sch
.subckt sram_2w2b_top VDD WLE DOUT0 VSS A0 WE WEB DIN0 DIN1 PCB EQEN DOUT1
*.PININFO VDD:B WLE:I DOUT0:O VSS:B A0:I WE:I WEB:I DIN0:I DIN1:I PCB:I EQEN:I DOUT1:O
x1 WL0 BL0 VDD BL1 BLB1 WL1 BLB0 VSS sram_2w2b
x2 VDD VSS WL0 WLE A0 WL1 decoder
x3 DIN0 VDD BL0 BLB0 VSS DIN1 BL1 WE BLB1 WEB write_driver
x4 VDD VSS PCB EQEN BL0 BLB0 BL1 BLB1 precharge
x5 VDD VSS BLB0 BLB1 DOUT0 DOUT1 read_buffer
.ends

* expanding   symbol:  sram_2w2b.sym # of pins=8
** sym_path: /home/take/Design/tr10_sram/Deliverables/sram_2w2b.sym
** sch_path: /home/take/Design/tr10_sram/Deliverables/sram_2w2b.sch
.subckt sram_2w2b WL0 BL0 VDD BL1 BLB1 WL1 BLB0 VSS
*.PININFO VDD:B VSS:B BL0:B BLB0:B BL1:B BLB1:B WL0:I WL1:I
x1 BL0 BLB0 WL0 VDD VSS sram6t_tr10
x2 BL1 BLB1 WL0 VDD VSS sram6t_tr10
x3 BL0 BLB0 WL1 VDD VSS sram6t_tr10
x4 BL1 BLB1 WL1 VDD VSS sram6t_tr10
.ends

* expanding   symbol:  decoder.sym # of pins=6
** sym_path: /home/take/Design/tr10_sram/Deliverables/decoder.sym
** sch_path: /home/take/Design/tr10_sram/Deliverables/decoder.sch
.subckt decoder VDD VSS WL0 WLE A0 WL1
*.PININFO VDD:B VSS:B WLE:I WL0:O WL1:O A0:I
MXM7 A0B A0 VDD VDD PMOS w=6.8u l=1u
MXM8 A0B A0 VSS VSS NMOS w=3.4u l=1u
MXM9 net2 WLE VDD VDD PMOS w=6.8u l=1u
MXM10 net1 WLE VSS VSS NMOS w=6.8u l=1u
MXM11 net2 A0B net1 VSS NMOS w=6.8u l=1u
MXM12 net2 A0B VDD VDD PMOS w=6.8u l=1u
MXM13 WL0 net2 VDD VDD PMOS w=6.8u l=1u
MXM14 WL0 net2 VSS VSS NMOS w=3.4u l=1u
MXM15 net4 WLE VDD VDD PMOS w=6.8u l=1u
MXM16 net3 WLE VSS VSS NMOS w=6.8u l=1u
MXM17 net4 A0 net3 VSS NMOS w=6.8u l=1u
MXM18 net4 A0 VDD VDD PMOS w=6.8u l=1u
MXM19 WL1 net4 VDD VDD PMOS w=6.8u l=1u
MXM20 WL1 net4 VSS VSS NMOS w=3.4u l=1u
.ends

* expanding   symbol:  write_driver.sym # of pins=10
** sym_path: /home/take/Design/tr10_sram/Deliverables/write_driver.sym
** sch_path: /home/take/Design/tr10_sram/Deliverables/write_driver.sch
.subckt write_driver DIN0 VDD BL0 BLB0 VSS DIN1 BL1 WE BLB1 WEB
*.PININFO DIN0:I DIN1:I WE:I WEB:I BL0:B BLB0:B BL1:B BLB1:B VDD:B VSS:B
MXM15 DIN0B DIN0 VDD VDD PMOS w=6.8u l=1u
MXM16 DIN0B DIN0 VSS VSS NMOS w=3.4u l=1u
MXM7 BL0 WE DIN0 VSS NMOS w=5.2u l=1u
MXM8 DIN0 WEB BL0 VDD PMOS w=6.8u l=1u
MXM1 BLB0 WE DIN0B VSS NMOS w=5.2u l=1u
MXM2 DIN0B WEB BLB0 VDD PMOS w=6.8u l=1u
MXM3 DIN1B DIN1 VDD VDD PMOS w=6.8u l=1u
MXM4 DIN1B DIN1 VSS VSS NMOS w=3.4u l=1u
MXM5 BL1 WE DIN1 VSS NMOS w=5.2u l=1u
MXM6 DIN1 WEB BL1 VDD PMOS w=6.8u l=1u
MXM9 BLB1 WE DIN1B VSS NMOS w=5.2u l=1u
MXM10 DIN1B WEB BLB1 VDD PMOS w=6.8u l=1u
.ends

* expanding   symbol:  precharge.sym # of pins=8
** sym_path: /home/take/Design/tr10_sram/Deliverables/precharge.sym
** sch_path: /home/take/Design/tr10_sram/Deliverables/precharge.sch
.subckt precharge VDD VSS PCB EQEN BL0 BLB0 BL1 BLB1
*.PININFO VDD:B VSS:B PCB:I EQEN:I BL0:B BLB0:B BL1:B BLB1:B
MXM9 BL0 PCB VDD VDD PMOS w=3.4u l=1u
MXM10 BLB0 PCB VDD VDD PMOS w=3.4u l=1u
MXM11 BL0 EQEN BLB0 VSS NMOS w=3.4u l=1u
MXM12 BL1 PCB VDD VDD PMOS w=3.4u l=1u
MXM13 BLB1 PCB VDD VDD PMOS w=3.4u l=1u
MXM14 BL1 EQEN BLB1 VSS NMOS w=3.4u l=1u
.ends

* expanding   symbol:  read_buffer.sym # of pins=6
** sym_path: /home/take/Design/tr10_sram/Deliverables/read_buffer.sym
** sch_path: /home/take/Design/tr10_sram/Deliverables/read_buffer.sch
.subckt read_buffer VDD VSS BLB0 BLB1 DOUT0 DOUT1
*.PININFO VDD:B VSS:B BLB0:I BLB1:I DOUT0:O DOUT1:O
MXM15 DOUT0 BLB0 VDD VDD PMOS w=6.8u l=1u
MXM16 DOUT0 BLB0 VSS VSS NMOS w=3.4u l=1u
MXM1 DOUT1 BLB1 VDD VDD PMOS w=6.8u l=1u
MXM2 DOUT1 BLB1 VSS VSS NMOS w=3.4u l=1u
.ends

* expanding   symbol:  /home/take/Design/tr10_sram/cell/sram6t_tr10.sym # of pins=5
** sym_path: /home/take/Design/tr10_sram/cell/sram6t_tr10.sym
** sch_path: /home/take/Design/tr10_sram/cell/sram6t_tr10.sch
.subckt sram6t_tr10 BL BLB WL VDD VSS
*.PININFO BL:B BLB:B WL:I VDD:B VSS:B
MXM1 Q QB VDD VDD PMOS w=3.4u l=1u
MXM2 QB Q VDD VDD PMOS w=3.4u l=1u
MXM4 QB Q VSS VSS NMOS w=6.8u l=1u
MXM3 Q QB VSS VSS NMOS w=6.8u l=1u
MXM5 BL WL Q VSS NMOS w=5.1u l=1u
MXM6 BLB WL QB VSS NMOS w=5.1u l=1u
.ends
