** sch_path: /home/take/Design/tr10_sram/array/2word_x_2bit/write_driver.sch
.subckt write_driver DIN0 VDD BL0 BLB0 VSS DIN1 BL1 WE BLB1 WEB
*.PININFO DIN0:I DIN1:I WE:I WEB:I BL0:B BLB0:B BL1:B BLB1:B VDD:B VSS:B
MXM15 DIN0B DIN0 VDD VDD PMOS w=6.8u l=1u
MXM16 DIN0B DIN0 VSS VSS NMOS w=3.4u l=1u
MXM7 BL0 WE DIN0 VSS NMOS w=5.2u l=1u
MXM8 DIN0 WEB BL0 VDD PMOS w=6.8u l=1u
MXM1 BLB0 WE DIN0B VSS NMOS w=5.2u l=1u
MXM2 DIN0B WEB BLB0 VDD PMOS w=6.8u l=1u
MXM3 DIN1B DIN1 VDD VDD PMOS w=6.8u l=1u
MXM4 DIN1B DIN1 VSS VSS NMOS w=3.4u l=1u
MXM5 BL1 WE DIN1 VSS NMOS w=5.2u l=1u
MXM6 DIN1 WEB BL1 VDD PMOS w=6.8u l=1u
MXM9 BLB1 WE DIN1B VSS NMOS w=5.2u l=1u
MXM10 DIN1B WEB BLB1 VDD PMOS w=6.8u l=1u
.ends
